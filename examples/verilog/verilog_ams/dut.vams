module dut(vout);
 output wreal vout;
 assign vout = 3.0;
endmodule
